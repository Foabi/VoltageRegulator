** Profile: "SCHEMATIC1-DCReg"  [ c:\cadence\labhw\projectfinal\voltagereg-pspicefiles\schematic1\dcreg.sim ]

** Creating circuit file "DCReg.cir"
** WARNING: THIS AUTOMATICALLY GENERATED FILE MAY BE OVERWRITTEN BY SUBSEQUENT SIMULATIONS

*Libraries:
* Profile Libraries :
* Local Libraries :
* From [PSPICE NETLIST] section of C:\Users\legion\AppData\Roaming\SPB_Data\cdssetup\OrCAD_PSpice\17.2.0\PSpice.ini file:
.lib "nom.lib"

*Analysis directives:
.TRAN  0 .1 0 1m
.WCASE TRAN V([N02522]) YMAX VARY BOTH  HI
.OPTIONS ADVCONV
.PROBE64 V(alias(*)) I(alias(*)) W(alias(*)) D(alias(*)) NOISE(alias(*))
.INC "..\SCHEMATIC1.net"

.END
